# Ansys Electronics Desktop project, version 2019.2
materials:
  vacuum: permittivity=1
  FR4_epoxy: permittivity=4.4 dielectric_loss_tangent=0.02
  air: permittivity=1.0006 permeability=1.0000004

design HFSSDesign1 (HFSS, DrivenModal, model units mm)
variables:
  Wp = 12*scale mm
  Lp = 23.5*scale mm
  W5 = 1*scale mm
  L5 = 8.5*scale mm
  W7 = 4*scale mm
  L7 = 1.6*scale mm
  L10 = 2.3*scale mm
  W6 = 1*scale mm
  L6 = 7.5*scale mm
  W9 = 2*scale mm
  Wf = 2.4*scale mm
  Lf = 15.1*scale mm
  W8 = 0.2*scale mm
  L8 = 4.3*scale mm
  W10 = 3*scale mm
  L9 = 16.3*scale mm
  W = 38*scale mm
  L = 40*scale mm
  substhickness = 1.6mm
  Lg = 14*scale mm
  W1 = 0.5*scale mm
  L1 = 3.5*scale mm
  W2 = 3*scale mm
  L2 = 6*scale mm
  W3 = 4*scale mm
  L3 = 2*scale mm
  W4 = 8*scale mm
  scale = 1.1
geometry:
  Patch = rectangle(corner=(0mm, 0mm, 0mm), x_size=Wp, y_size=Lp)
  Rectangle2 = rectangle(corner=(1mm, Lp-L5, 0mm), x_size=W5, y_size=L5)
  Patch.subtract(Rectangle2)  # suppressed
  Rectangle3 = rectangle(corner=(WP-W7, LP-L10-L7, 0mm), x_size=W7, y_size=L7)
  Patch.subtract(Rectangle3)
  Rectangle4 = rectangle(corner=(WP-W9-W6, 0mm, 0mm), x_size=W6, y_size=L6)
  Patch.subtract(Rectangle4)
  Rectangle5 = rectangle(corner=((Wp-Wf)/2, 0mm, 0mm), x_size=Wf, y_size=-Lf)
  Rectangle6 = rectangle(corner=(Wp/2-W10/2 -W8, 0mm, 0mm), x_size=W8, y_size=L8)
  Rectangle7 = rectangle(corner=(Wp/2 + W10/2, 0mm, 0mm), x_size=W8, y_size=L8)
  Patch.subtract(Rectangle6, Rectangle7)
  Patch.unite(Rectangle5)
  Circle1 = circle(normal=Z, centre=(Wp/2, L9+W10/2, 0mm), radius=W10/2)
  Patch.subtract(Circle1)
  Substrate [FR4_epoxy] = box(corner=(-W/2+Wp/2, -Lf, 0mm), size=(W, L, -substhickness))
  Ground = rectangle(corner=(-W/2+Wp/2, -Lf, -substhickness), x_size=W, y_size=Lg)
  Rectangle9 = rectangle(corner=(Wp/2+W/2-W4, -Lf+Lg, -substhickness), x_size=W2, y_size=-L2)
  Rectangle10 = rectangle(corner=(Wp/2+W/2-W4-W3, -Lf+Lg-L2, -substhickness), x_size=W3, y_size=L3)
  Ground_1 = rectangle(corner=(-4.5mm*scale, -Lf+Lg, -substhickness), x_size=W1, y_size=L1)
  Source = rectangle(corner=(Wp/2 - Wf/2, -Lf, 0mm), z_size=-substhickness, x_size=Wf)
  Box1 [air] = box(corner=(80mm*scale, -50mm*scale, -5mm*scale), size=(-120mm*scale, +120mm*scale, 60mm*scale))
  Rectangle9.unite(Rectangle10)
  Ground.subtract(Rectangle9)
  Ground_1.unite(Ground)
boundaries and excitations:
  PerfE2: Perfect E Objects=Patch
  PerfE3: Perfect E Objects=Ground_1
  Rad1: Radiation Objects=Box1
  1: Lumped Port Objects=Source Modes{Mode1{IntLine{middle of Source.edge(z opposite corner) -> middle of Source.edge(z at corner)} CharImp=Zpi}} Impedance=50ohm
setups:
  Setup1: HfssDriven Frequency=2GHz MaxDeltaS=0.02 MaximumPasses=20 MinimumPasses=1 MinimumConvergedPasses=1 PercentRefinement=30 BasisOrder=1 PortAccuracy=2
    sweep Sweep: 500MHz to 10GHz, 451 points; Type=Interpolating InterpTolerance=0.5 InterpMaxSolns=250 InterpUsePortImped=false PassivityErrorTolerance=0.0001
source amplitudes:
  1:1: 1W 0deg
radiation setups:
  Infinite Sphere1: Infinite Sphere Theta=-180deg..180deg step 10deg Phi=0deg..360deg step 10deg
reports:
  S Parameter Plot 1: dB(S(1,1)) vs Freq on Setup1 : Sweep; markers m1 at 1.5344444GHz, m2 at 4.87GHz, MX1 at x=4.8611641e+09, MX2 at x=1.5301903e+09
  VSWR Plot 1: VSWR(1) vs Freq on Setup1 : Sweep [substhickness=all]
  Polarization -  ThetaPhi: dB(DirPhi), dB(DirTheta) vs Theta on Setup1 : LastAdaptive, Infinite Sphere1 [Phi=0deg Freq=2GHz]
  Polarization - XY: dB(DirX), dB(DirY) vs Theta on Setup1 : LastAdaptive, Infinite Sphere1 [Phi=0deg Freq=2GHz]
  Group Delay Plot 1: GroupDelay(1,1) vs Freq on Setup1 : Sweep
  Theta = 90 degee: dB(GainTotal) vs Phi on Setup1 : LastAdaptive, Infinite Sphere1 [Theta=80deg Freq=2GHz]
  Gain Plot 1: dB(GainTotal) vs Phi, Theta on Setup1 : LastAdaptive, Infinite Sphere1 [Freq=2GHz]
  Port Zo Plot 1: re(Zo(1)), im(Zo(1)) vs Freq on Setup1 : Sweep
  Z Parameter Plot 1: dB20(Z(1,1)) vs Freq on Setup1 : Sweep
